* Auto Azimuth P.C.B. — power decoupling and manual-control input (partial)
* UNREVIEWED DRAFT - not a verified/simulation-ready circuit
* Evidence: PDF pages 45; coverage=partial
* Node names are schematic transcription hypotheses, not measurements.
* C911: page 45, region [0.28, 0.38, 0.42, 0.52]
C911 V12_pos_rail GND_rail 470u
* C912: page 45, region [0.28, 0.42, 0.42, 0.55]
C912 V12_neg_rail GND_rail 470u
* R741: page 45, region [0.3, 0.28, 0.45, 0.4]
R741 K_down_in D741_anode 390K
* R742: page 45, region [0.35, 0.3, 0.5, 0.42]
R742 IC741_pin6 IC741_pin4 180K
* R743: page 45, region [0.35, 0.3, 0.5, 0.42]
R743 IC741_pin5 IC741_pin6 390K
* R744: page 45, region [0.35, 0.3, 0.5, 0.42]
R744 IC741_pin5 IC741_pin7 180K
* R747: page 45, region [0.3, 0.35, 0.45, 0.45]
* OMITTED R747: Far node exits the visible crop; marked boundary.
* IC741: page 45, region [0.3, 0.25, 0.55, 0.45]
* OMITTED IC741: Pin 1 and pin 8 (power) connections extend to rails outside the selected crop.
* No supply, stimulus, device model or analysis has been fabricated.
.end

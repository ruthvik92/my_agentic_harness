* Trap Unit L701 and IC701 (1/2) - bottom-left of PDF page 44
* UNREVIEWED DRAFT - not a verified/simulation-ready circuit
* Evidence: PDF pages 44; coverage=partial
* Node names are schematic transcription hypotheses, not measurements.
* R715: page 44, region [0.0, 0.5, 0.5, 1.0]
R715 ic602_3_4_out ic701_1_2_inv_in 100
* C705: page 44, region [0.0, 0.5, 0.5, 1.0]
C705 trap_input_net ic602_3_4_in 3900p
* VR701: page 44, region [0.0, 0.5, 0.5, 1.0]
* OMITTED VR701: active device/connector requires explicit pin mapping and a reviewed model
* R710: page 44, region [0.0, 0.5, 0.5, 1.0]
* OMITTED R710: Value not readable in the provided crop; resistor is clearly present as feedback element.
* No supply, stimulus, device model or analysis has been fabricated.
.end
